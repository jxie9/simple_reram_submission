.subckt Final_top_wrapper vdda2_pin vccd2_pin vssa2_pin Write_select_in Write_form_select_in BL_LA_IN1 BL_LA_IN2 BL_LA_IN3
+ BL_LA_IN4 SL1_out SL2_out WL_LA_IN1 SL3_out WL_LA_IN2 SL4_out WL_LA_IN3 WL_LA_IN4 vssd2_pin
x2 vssa2_pin BL_IN1 BL_IN2 BL_IN3 BL_IN4 WL_IN1 WL_IN2 WL_IN3 WL_IN4 SL1_out SL2_out SL3_out SL4_out 4x4crossbar
x7 vdda2_pin v3 vssa2_pin vDivider_3
x8 vdda2_pin v25 vssa2_pin vDivider_25
x10 vccd2_pin v02 vssd2_pin vDivider_02
x3 vdda2_pin vssa2_pin Write_select_in v25 v3 BL_LA_IN1 Write_form_select_in v02 BL_IN1 BL_LA_IN2 BL_IN2 BL_LA_IN3 BL_IN3
+ BL_LA_IN4 BL_IN4 4LineBitInput
x4 vdda2_pin vssa2_pin Write_select_in v25 v25 WL_LA_IN1 WL_IN1 WL_LA_IN2 WL_IN2 WL_LA_IN3 WL_IN3 WL_LA_IN4 WL_IN4 4LineWordInput
.ends

* expanding   symbol:  4x4crossbar.sym # of pins=13
** sym_path: /home/jason/reram_precheck_top/caravel_user_project_analog/xschem/4x4crossbar.sym
** sch_path: /home/jason/reram_precheck_top/caravel_user_project_analog/xschem/4x4crossbar.sch
.subckt 4x4crossbar VSS BL1 BL2 BL3 BL4 WL1 WL2 WL3 WL4 SL1 SL2 SL3 SL4
*.PININFO BL1:B BL2:B SL2:B SL1:B BL3:B BL4:B SL4:B SL3:B WL2:B WL1:B WL4:B WL3:B VSS:B
x1 VSS BL2 BL1 WL1 WL2 SL2 SL1 2x2crossbar
x2 VSS BL2 BL1 WL3 WL4 SL2 SL1 2x2crossbar
x3 VSS BL4 BL3 WL1 WL2 SL4 SL3 2x2crossbar
x4 VSS BL4 BL3 WL3 WL4 SL4 SL3 2x2crossbar
.ends

* expanding   symbol:  vDivider_3.sym # of pins=3
** sym_path: /home/jason/reram_precheck_top/caravel_user_project_analog/xschem/vDivider_3.sym
** sch_path: /home/jason/reram_precheck_top/caravel_user_project_analog/xschem/vDivider_3.sch
.subckt vDivider_3 VCC Y VSS
*.PININFO VCC:I VSS:I Y:O
XR3 Y VCC sky130_fd_pr__res_generic_po W=1 L=1.65 m=1
XR1 VSS Y sky130_fd_pr__res_generic_po W=1 L=16.5 m=1
.ends

* expanding   symbol:  vDivider_25.sym # of pins=3
** sym_path: /home/jason/reram_precheck_top/caravel_user_project_analog/xschem/vDivider_25.sym
** sch_path: /home/jason/reram_precheck_top/caravel_user_project_analog/xschem/vDivider_25.sch
.subckt vDivider_25 VCC Y VSS
*.PININFO VCC:I VSS:I Y:O
XR3 Y VCC sky130_fd_pr__res_generic_po W=1 L=8 m=1
XR1 VSS Y sky130_fd_pr__res_generic_po W=1 L=25 m=1
.ends

* expanding   symbol:  vDivider_02.sym # of pins=3
** sym_path: /home/jason/reram_precheck_top/caravel_user_project_analog/xschem/vDivider_02.sym
** sch_path: /home/jason/reram_precheck_top/caravel_user_project_analog/xschem/vDivider_02.sch
.subckt vDivider_02 VCC Y VSS
*.PININFO VCC:I VSS:I Y:O
XR3 Y VCC sky130_fd_pr__res_generic_po W=1 L=13.2 m=1
XR1 VSS Y sky130_fd_pr__res_generic_po W=1 L=1.65 m=1
.ends

* expanding   symbol:  4LineBitInput.sym # of pins=15
** sym_path: /home/jason/reram_precheck_top/caravel_user_project_analog/xschem/4LineBitInput.sym
** sch_path: /home/jason/reram_precheck_top/caravel_user_project_analog/xschem/4LineBitInput.sch
.subckt 4LineBitInput VDD VSS Write_Select v25 v3 BL_LA_IN1 Write_Form_Select v02 BL_IN1 BL_LA_IN2 BL_IN2 BL_LA_IN3 BL_IN3
+ BL_LA_IN4 BL_IN4
*.PININFO Write_Select:I BL_LA_IN1:I BL_LA_IN2:I BL_LA_IN3:I BL_LA_IN4:I BL_IN1:O BL_IN2:O BL_IN3:O BL_IN4:O v25:I v3:I
*+ Write_Form_Select:I v02:I VDD:B VSS:B
x7 VDD net1 VSS BL_LA_IN1 Write_Form_Select BL_IN1 v02 1LineBitInput
x8 VDD net1 VSS BL_LA_IN2 Write_Form_Select BL_IN2 v02 1LineBitInput
x10 VDD net1 VSS BL_LA_IN3 Write_Form_Select BL_IN3 v02 1LineBitInput
x14 VDD net1 VSS BL_LA_IN4 Write_Form_Select BL_IN4 v02 1LineBitInput
x15 VDD Write_Select v25 net1 v3 VSS 2-1MUX
.ends

* expanding   symbol:  4LineWordInput.sym # of pins=13
** sym_path: /home/jason/reram_precheck_top/caravel_user_project_analog/xschem/4LineWordInput.sym
** sch_path: /home/jason/reram_precheck_top/caravel_user_project_analog/xschem/4LineWordInput.sch
.subckt 4LineWordInput VDD VSS Write_Select Write_Voltage Form_Voltage WL_LA_IN1 WL_IN1 WL_LA_IN2 WL_IN2 WL_LA_IN3 WL_IN3
+ WL_LA_IN4 WL_IN4
*.PININFO WL_LA_IN1:I WL_LA_IN2:I WL_LA_IN3:I WL_LA_IN4:I Write_Select:I Write_Voltage:I Form_Voltage:I WL_IN1:O WL_IN2:O WL_IN3:O
*+ WL_IN4:O VDD:B VSS:B
x3 net1 WL_LA_IN1 WL_IN1 VSS Buffer
x4 net1 WL_LA_IN2 WL_IN2 VSS Buffer
x5 net1 WL_LA_IN3 WL_IN3 VSS Buffer
x6 net1 WL_LA_IN4 WL_IN4 VSS Buffer
x9 VDD Write_Select Write_Voltage net1 Form_Voltage VSS 2-1MUX
.ends

* expanding   symbol:  2x2crossbar.sym # of pins=7
** sym_path: /home/jason/reram_precheck_top/caravel_user_project_analog/xschem/2x2crossbar.sym
** sch_path: /home/jason/reram_precheck_top/caravel_user_project_analog/xschem/2x2crossbar.sch
.subckt 2x2crossbar VSS BL2 BL1 WL1 WL2 SL2 SL1
*.PININFO BL2:B BL1:B WL1:B WL2:B SL1:B SL2:B VSS:B
x1 BL1 WL1 SL1 VSS 1T1R
x2 BL2 WL1 SL2 VSS 1T1R
x3 BL1 WL2 SL1 VSS 1T1R
x4 BL2 WL2 SL2 VSS 1T1R
.ends

* expanding   symbol:  1LineBitInput.sym # of pins=7
** sym_path: /home/jason/reram_precheck_top/caravel_user_project_analog/xschem/1LineBitInput.sym
** sch_path: /home/jason/reram_precheck_top/caravel_user_project_analog/xschem/1LineBitInput.sch
.subckt 1LineBitInput VDD VDD_MUX VSS BL_LA_IN Write_Form_select BL_IN MAC_Read
*.PININFO BL_LA_IN:I Write_Form_select:I MAC_Read:I VDD:B VDD_MUX:B VSS:B BL_IN:O
x2 VDD Write_Form_select net1 BL_IN MAC_Read VSS 2-1MUX
x3 VDD_MUX BL_LA_IN net1 VSS Buffer
.ends

* expanding   symbol:  2-1MUX.sym # of pins=6
** sym_path: /home/jason/reram_precheck_top/caravel_user_project_analog/xschem/2-1MUX.sym
** sch_path: /home/jason/reram_precheck_top/caravel_user_project_analog/xschem/2-1MUX.sch
.subckt 2-1MUX VDD S A OUT B VSS
*.PININFO A:I B:I S:I VDD:B VSS:B OUT:O
x1 net1 VDD OUT A VSS S TransmissionGate
x2 S VDD OUT B VSS net1 TransmissionGate
x3 VDD S net1 VSS Inverter
.ends

* expanding   symbol:  Buffer.sym # of pins=4
** sym_path: /home/jason/reram_precheck_top/caravel_user_project_analog/xschem/Buffer.sym
** sch_path: /home/jason/reram_precheck_top/caravel_user_project_analog/xschem/Buffer.sch
.subckt Buffer VDD Vin Vout VSS
*.PININFO VDD:B VSS:B Vin:I Vout:O
x1 VDD Vin net1 VSS Inverter
x2 VDD net1 Vout VSS Inverter
.ends

* expanding   symbol:  1T1R.sym # of pins=4
** sym_path: /home/jason/reram_precheck_top/caravel_user_project_analog/xschem/1T1R.sym
** sch_path: /home/jason/reram_precheck_top/caravel_user_project_analog/xschem/1T1R.sch
.subckt 1T1R BL WL SL VSS
*.PININFO SL:B WL:B BL:B VSS:B
XR1 BL net1 sky130_fd_pr_reram__reram_cell Tfilament_0=3.8e-9 area_ox=1
XM1 net1 WL SL VSS sky130_fd_pr__nfet_g5v0d10v5 L=0.5 W=7 nf=1 m=1
.ends

* expanding   symbol:  TransmissionGate.sym # of pins=6
** sym_path: /home/jason/reram_precheck_top/caravel_user_project_analog/xschem/TransmissionGate.sym
** sch_path: /home/jason/reram_precheck_top/caravel_user_project_analog/xschem/TransmissionGate.sch
.subckt TransmissionGate SP VDD Out In VSS SN
*.PININFO Out:O In:I SP:I VDD:B VSS:B SN:I
XM1 In SN Out VSS sky130_fd_pr__nfet_g5v0d10v5 L=0.5 W=0.75 nf=1 m=1
XM2 In SP Out VDD sky130_fd_pr__pfet_g5v0d10v5 L=0.5 W=1.5 nf=1 m=1
.ends

* expanding   symbol:  Inverter.sym # of pins=4
** sym_path: /home/jason/reram_precheck_top/caravel_user_project_analog/xschem/Inverter.sym
** sch_path: /home/jason/reram_precheck_top/caravel_user_project_analog/xschem/Inverter.sch
.subckt Inverter VDD Vin Vout VSS
*.PININFO Vin:I VDD:B VSS:B Vout:O
XM1 Vout Vin VSS VSS sky130_fd_pr__nfet_g5v0d10v5 L=0.5 W=0.75 nf=1 m=1
XM2 Vout Vin VDD VDD sky130_fd_pr__pfet_g5v0d10v5 L=0.5 W=1.5 nf=1 m=1
.ends

.end
